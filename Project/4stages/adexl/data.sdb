ADE simulation setup
Run mode: Single Run, Sweeps and Corners
Tests:
  Omar:4stages:1: Omar/4stages/schematic, simulator spectre
