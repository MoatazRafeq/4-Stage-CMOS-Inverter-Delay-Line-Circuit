ADE simulation setup
Run mode: Single Run, Sweeps and Corners
Tests:
  Omar:TB:1: Omar/TB/config, simulator spectre
    Outputs: Delay
Global variables:
  VDD = 1.2
